`include "constants.vams"
`include "disciplines.vams"

nature distance
  access = Metr;
  units = "m";
  abstol = 0.01n;
endnature

discipline Distance
  potential distance;
enddiscipline

module DW_kinematic_model(P, Q, DW_Position, RA, DW_Velocity, DW_MC, DW_Req,DW_J,A_J,
    A_k5,A_k6);

inout P, Q;					//P is defined as the left port of the DW track, and Q is the right port.
inout RA;					//MTJ output port
output DW_Position;				//This port measures the DW position, in meters
output DW_Velocity;				//This port measures the DW velocity, in meters
output DW_MC;					//This port measures the effective DW track current, in Amps.
output DW_J;					//This port measures the effective DW track current density, in Amps.

// Ports measuring various acceleration contributions, for tracking
output A_J;
output A_k5;
output A_k6;

electrical P, Q;
electrical RA;
electrical Vmiddle;

Distance DW_Position;
Distance DW_Velocity;
Distance DW_MC;
Distance DW_J;
Distance DW_Req;

parameter real I_th = 1n;			// threshold current for DW motion

// Resistance parameters
parameter real Rp = 1k;
parameter real Rap = 1M;
parameter real R_init = 10k;
parameter real Rtotal = 3.9k;

// DW track length and MTJ position
parameter real Pdw_init = 0;
parameter real Pdw_limit = 120n;
parameter real Pdw_low = 20n;
parameter real Pdw_high = 40n;

//------------------------------------MTJ resistance voltage dependence section

parameter real Switch_MTJ_VoltageDependent = 0;
parameter real MTJ_VoltageDependent_Factor = 1;
parameter real MTJ_VoltageDependent_MinValue = 0.4;

//------------------------------------MTJ resistance voltage dependence section end

parameter real dt = 1e-3;			// time step (in ns)

// micromagnetic parameters
parameter real Aex = 11e-12;
parameter real Xi = 0.01;
parameter real Ku = 9.17e5;
parameter real Msat = 1.2e6;
parameter real alpha = 0.01;
parameter real DW_width = 50e-9;
parameter real DW_thickness = 1.2e-9;
parameter real Areaa = 1.2e-9*50e-9;		// cross section area of heavy metal layer
parameter real thetaSH = 0.05;
real B_anis = 0;				// B_anis calculated from other params

parameter real c_r = 0.25;			// coefficient of restitution, controls track end bounce,
    between 0 and 1

// Domain Wall motion variables
real Pdw;				//measured in m, not nm
real Vdw;
real Adw;

// Resistance variables
real Req;
real RR;
real RL;

// Current density variables
real Jdenss;
real J_sign;
real J_init;
real IPQPQ;
real prev_time;

// model constants
real c0; //Change to "parameter real" to set manually.
real c1; //Change to "parameter real" to set manually.
real c2; //Change to "parameter real" to set manually.
real c3; //Change to "parameter real" to set manually.
real drift_const; //Change to "parameter real" to set manually.

real k0;
real k1;
real k2;
real k3;
real k4;
real k5;
real k6; //Change to "parameter real" to set manually.

Distance A_J;
Distance A_k5;
Distance A_k6;

//------------------------------------MTJ resistance voltage dependence section

real Rp_eq;
real Rap_eq;
real VMTJ_eq;

//------------------------------------MTJ resistance voltage dependence section end

analog
begin
	@(initial_step)
	begin

		Rp_eq = Rp;
		Rap_eq = Rap;

		Pdw = Pdw_init;
		Vdw = 0;

		Jdenss = 0;
		J_init = 0;

		//Req = (((Pdw_limit - Pdw) / Pdw_limit ) * Rap) + ((Pdw / Pdw_limit) * Rp) ;
		Req = R_init;

		if(Ku == 1.11e6 || Ku == 5.36e5)
		begin
    			B_anis = 350;
		end
		else if(Ku == 9.17e5 || Ku == 4.05e5)
		begin
    			B_anis = 20;
		end
		else if(Ku == 7.01e5)
		begin
			B_anis = 150;
		end
		else
		begin
    			B_anis = (Ku/(0.5*Msat) - (4*`M_PI*1e-7)*Msat)*1000;
		end

//Comment out the following block if constants c0-c3, drift_const, and k6 manually set.
		//read in constant values for specific parameter corner from lookup table files
    (included on github).
		c0 = $table_model (Aex*1e12, Xi, B_anis,alpha,Msat,DW_width*1e9,
    "lookup_maxVel_c0.tbl", "1L,1L,1L,1L,1L,1L");
		c1 = $table_model (Aex*1e12, Xi, B_anis,alpha,Msat,DW_width*1e9,
    "lookup_maxVel_c1.tbl", "1L,1L,1L,1L,1L,1L");
		c2 = $table_model (Aex*1e12, Xi, B_anis,alpha,Msat,DW_width*1e9,
    "lookup_maxVel_c2.tbl", "1L,1L,1L,1L,1L,1L");
		c3 = $table_model (Aex*1e12, Xi, B_anis,alpha,Msat,DW_width*1e9,
    "lookup_maxVel_c3.tbl", "1L,1L,1L,1L,1L,1L");
		drift_const = $table_model (Aex*1e12, Xi, B_anis,alpha,Msat,DW_width*1e9,
    "lookup_drift_const.tbl", "1L,1L,1L,1L,1L,1L");
		k6 = $table_model (Aex*1e12, Xi, B_anis,alpha,Msat,DW_width*1e9,
    "lookup_k6.tbl", "1L,1L,1L,1L,1L,1L");

		// calculate other constants
		k5 =  1/drift_const;
		k0 = k5*c0;
    		k1 = k5*c1 + k6*c0;
    		k2 = k5*c2 + k6*c1;
    		k3 = k5*c3 + k6*c2;
    		k4 = k6*c3;

	end

	//if pos of DW below (left of) MTJ, current through wall determined by left pin (P) and
    MTJ voltage
	if(Pdw < ((Pdw_low + Pdw_high)/2))
	begin
		IPQPQ = I(P, Vmiddle);
	end
	else
	begin
		IPQPQ = I(Vmiddle, Q);
	end

	//Conversion of current through heavy metal layer to current density
	if(abs(IPQPQ) >= I_th)
	begin
		Jdenss = thetaSH*(IPQPQ / Areaa);
	end
	else
	begin
		Jdenss = 0;
	end

	// find sign of current density
	J_sign = 0;
	if(Jdenss >0)
	begin
		J_sign = 1;
	end
	else if(Jdenss<0)
	begin
		J_sign = -1;
	end
	else
	begin
		J_sign = 0;
	end

	// Calculation of acceleration, velocity, position
	Adw = - J_sign*(k0 + k4*(abs(Jdenss)**4) + k3*(abs(Jdenss)**3) + k2*(abs(Jdenss)**2) +
    k1*abs(Jdenss)) - (k5 + k6*abs(Jdenss))*Vdw;	// [nm/ns^2]
	Vdw = Vdw + Adw * dt;															// [nm/ns = m/s]
	Pdw = Pdw + Vdw * dt*1e-9;														// [m]

//---------------------------------------Edge bounce

	if(Pdw<=0)
	begin
		Pdw = 0;
		Vdw = -c_r*Vdw;
	end
	else if(Pdw>=Pdw_limit)
	begin
		Pdw = Pdw_limit;
		Vdw = -c_r*Vdw;
	end

//------------------------------------MTJ resistance voltage dependence section

	if(Switch_MTJ_VoltageDependent == 1)
	begin

		VMTJ_eq = V(RA, Vmiddle);

		Rap_eq = (1 - VMTJ_eq * MTJ_VoltageDependent_Factor) * Rap;

		if(Rap_eq < MTJ_VoltageDependent_MinValue * Rap)
		begin
			Rap_eq = MTJ_VoltageDependent_MinValue * Rap;
		end

	end

//------------------------------------MTJ resistance voltage dependence section end

	if(Pdw <= Pdw_low && Pdw >=0)
	begin
		Req = Rp_eq;
	end
	else if(Pdw >= Pdw_high && Pdw <= Pdw_limit)
	begin
		Req = Rap_eq;
	end
	else
	begin

		Req = ((Pdw_high - Pdw_low) * Rp_eq * Rap_eq) / ((Rp_eq * (Pdw - Pdw_low)) + ( Rap_eq
    * (Pdw_high - Pdw)));
	end

	RR = (Pdw_limit-Pdw_low-10n)/(Pdw_limit)*Rtotal;
	RL = Rtotal - RR;

	// calculate currents through device
	I(P, Vmiddle) <+ V(P, Vmiddle) / RL;
	I(Q, Vmiddle) <+ V(Q, Vmiddle) / RR;

	I(Vmiddle, RA) <+ V(Vmiddle, RA) / Req;

	// Components of acceleration split up, measurable on ports
	Metr(A_J) <+ - J_sign*(k0 + k4*(abs(Jdenss)**4) + k3*(abs(Jdenss)**3) +
    k2*(abs(Jdenss)**2) + k1*abs(Jdenss));
	Metr(A_k5) <+ -k5*Vdw;
	Metr(A_k6) <+ - k6*abs(Jdenss)*Vdw;

	// domain wall motion variables, current and current density measurable on ports
	Metr(DW_Req) <+ Req;
	Metr(DW_Position) <+ Pdw;
	Metr(DW_Velocity) <+ Vdw;
	Metr(DW_MC) <+ IPQPQ;
	Metr(DW_J) <+ Jdenss/1e9;

end
endmodule
